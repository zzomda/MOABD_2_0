*** Title: "E:\WORCK\LR_2_SH\simulation\tb_cnt_grey\netlistLR_2_SH_NID.cir"
*** Generated by:  Symica
*** © 2009-2014 Symica. All rights reserved. (www.symica.com)
*** Generated for: SymSpice
*** Generated on:  Sat Feb 14 15:03:25 2026
*******************************************************************
*** This is a root file of the project
*******************************************************************

simulator lang=local

global gnd vdd!

include "E:\Symica Free\lib\models\mos.lib"
