*** Title: "E:\WORCK\LR_2_SH\simulation\tb_zd_vdva\netlistLR_2_SH_NID.cir"
*** Generated by:  Symica
*** © 2009-2014 Symica. All rights reserved. (www.symica.com)
*** Generated for: SymSpice
*** Generated on:  Mon Feb 23 01:22:14 2026
*******************************************************************
*** This is a root file of the project
*******************************************************************

simulator lang=local

global gnd vdd!

include "E:\Symica Free\lib\models\mos.lib"
